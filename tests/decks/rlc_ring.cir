Series RLC step response (underdamped)
V1 in 0 PULSE(0 1 0 1n 1n 1 2) AC 1
R1 in a 10
L1 a b 1m
C1 b 0 1u
.tran 1u 2m
.ac dec 20 100 100k
.end
