Silicon junctions at -20 C
V1 in 0 DC 5
R1 in d 1k
D1 d 0 DM
.model DM D(IS=1e-14 N=1)
.temp -20
.op
.end
