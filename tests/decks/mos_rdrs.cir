NMOS with drain and source series resistance (source degeneration)
VDD vdd 0 DC 12
VG g 0 DC 4
RD vdd d 500
M1 d g s s NM W=1u L=1u
RS2 s 0 100
.model NM NMOS(LEVEL=1 VTO=2 KP=0.01 LAMBDA=0.02 RD=30 RS=20)
.op
.dc VG 0 6 0.5
.end
