Biased CMOS inverter small-signal response with Meyer gate capacitances
VDD vdd 0 DC 3.3
VIN in 0 DC 1.45 AC 1
MP out in vdd vdd PM W=20u L=1u
MN out in 0 0 NM W=10u L=1u
CL out 0 50f
.model NM NMOS(LEVEL=1 VTO=0.6 KP=100u GAMMA=0.4 PHI=0.7 LAMBDA=0.03 TOX=10n CGSO=2e-10 CGDO=2e-10 CJ=3e-4 IS=1e-14)
.model PM PMOS(LEVEL=1 VTO=-0.7 KP=40u GAMMA=0.5 PHI=0.7 LAMBDA=0.04 TOX=10n CGSO=2e-10 CGDO=2e-10 CJ=3e-4 IS=1e-14)
.op
.ac dec 10 1Meg 10G
.end
