NMOS with body effect (bulk below source), overlap and junction capacitances, and a source follower
VDD vdd 0 DC 5
VB bb 0 DC -1
VIN in 0 SIN(2.5 0.2 100k) AC 0.2
RD vdd d 2k
M1 d in s bb NB W=20u L=2u AD=40p AS=40p PD=24u PS=24u
RS s 0 3k
CL d 0 1p
.model NB NMOS(LEVEL=1 VTO=0.7 KP=60u GAMMA=0.5 PHI=0.65 LAMBDA=0.02 IS=1e-14 PB=0.8 CJ=2e-4 CJSW=3e-10 MJ=0.5 MJSW=0.33 CGSO=3e-10 CGDO=3e-10 CGBO=2e-10)
.op
.ac dec 10 1k 1G
.tran 5n 40u
.end
