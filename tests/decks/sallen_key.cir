Sallen-Key low-pass (VCVS op-amp), fc ~ 1.6 kHz
V1 in 0 DC 0 AC 1
R1 in a 10k
R2 a b 10k
C1 a out 10n
C2 b 0 10n
E1 out 0 b 0 1.586
.ac dec 20 10 100k
.end
